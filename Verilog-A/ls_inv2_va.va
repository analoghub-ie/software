// Level shifter with inversion (digital)
// Author: A. Sidun
// Source: AnalogHub.ie

`include "constants.vams"
`include "disciplines.vams"

module level_shifter_inv (inp, inn, outn, outp, low, high);
    input inp, inn, low, high;
    output outp, outn;
    electrical inp, inn, outp, outn, low, high;
    parameter real VDD = 5.0; // Output voltage during high state

analog begin

@(initial_step)
	V(outp) <+ V(high);
	V(outn) <+ V(low);

 	if ((V(inp)-V(inn)) > VDD/2) begin
		V(outp) <+ V(high);
		V(outn) <+ V(low);
	end

	if ((V(inp)-V(inn)) < VDD/2) begin
		V(outp) <+ V(low);
		V(outn) <+ V(high);
	end
end

endmodule
