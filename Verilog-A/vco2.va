// VCO model
// Model 2: Gain (V/Hz) is set through start/stop frequency
// Author: A. Sidun
// Source: AnalogHub.ie

`include "constants.vams"
`include "disciplines.vams"

// Model 2: Gain (V/Hz) is set through start/stop frequency
module vco(out,in);
voltage out,in;
parameter real DC_offset = 1;
parameter real Amplitude = 1;
parameter real Points_per_period = 100;
parameter real Start_frequency = 1e6;
parameter real Stop_frequency = 10e6;
real phase, freq, gain;

	analog begin
		gain = Stop_frequency/Start_frequency;
		freq = Start_frequency+gain*V(in);
		phase = idtmod(freq,0,1);
		V(out) <+ DC_offset+Amplitude*cos(2*`M_PI*phase);
		$bound_step(1/(Points_per_period*freq));
	end
endmodule
